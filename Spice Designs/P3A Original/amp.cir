*

.MODEL bc546b NPN( IS=2.39E-14 NF=1.008 ISE=3.545E-15 NE=1.541 BF=294.3
+ IKF=0.1357 VAF=63.2 NR=1.004 ISC=6.272E-14 NC=1.243 BR=7.946 IKR=0.1144
+ VAR=25.9 RB=1 IRB=1E-06 RBM=1 RE=0.4683 RC=0.85 XTB=0 EG=1.11 XTI=3
+ CJE=1.358E-11 VJE=0.65 MJE=0.3279 TF=4.391E-10 XTF=120 VTF=2.643
+ ITF=0.7495 PTF=0 CJC=3.728E-12 VJC=0.3997 MJC=0.2955 XCJC=0.6193 TR=1E-32
+ CJS=0 VJS=0.75 MJS=0.333 FC=0.9579 )

.model TIP35 NPN (IS=1.84P NF=1 BF=81.5 VAF=161 IKF=8.33 ISE=1.97N NE=2
+ BR=4 NR=1 VAR=20 IKR=12.5 RE=13.2M RB=53M RC=5.3M XTB=1.5
+ CJE=801P VJE=.6 MJE=.3 CJC=520P VJC=.22 MJC=.2 TF=54.1N TR=2.08U)
.model TIP36 PNP (IS=1.84P NF=1 BF=65 VAF=161 IKF=8.33 ISE=2.47N NE=2
+ BR=4 NR=1 VAR=20 IKR=12.5 RE=13.2M RB=53M RC=5.3M XTB=1.5
+ CJE=1.81N VJE=.6 MJE=.3 CJC=1.17N VJC=.22 MJC=.2 TF=54.1N TR=2.08U)
* ---------- BD139 NGSpice-safe model ----------
.model BD139 NPN (
+ IS=0.271E-16
+ BF=204.072
+ VAF=158.022
+ IKF=5.018
+ ISE=0.137E-17
+ NE=1.712
+ BR=1.127
+ VAR=10.749
+ IKR=0.435
+ ISC=0.128E-17
+ NC=1.046
+ RB=0.571
+ RBM=0.101E-02
+ NF=0.982
+ RE=0.259E-01
+ RC=0.413E-01
+ CJC=0.361E-10
+ VJC=0.776
+ MJC=0.409
+ CJE=0.102E-10
+ VJE=0.745
+ MJE=0.404
+ FC=0.503
+ TR=0.118E-06
+ TF=0.296E-08
+ ITF=0.229
+ VTF=23.728
+ XTF=0.569
+)

* ---------- BD140 NGSpice-safe model ----------
.model BD140 PNP (
+ IS=0.188E-16
+ BF=201.325
+ VAF=39.764
+ IKF=0.521
+ ISE=0.447E-15
+ NE=2.771
+ BR=0.671E-01
+ VAR=131.148
+ IKR=0.494
+ ISC=0.921E-12
+ NC=1.674
+ RB=0.572E-01
+ RBM=0.335E-02
+ NF=0.981
+ RE=0.185E-02
+ RC=0.127
+ CJC=0.469E-12
+ VJC=0.715
+ MJC=0.313
+ CJE=0.297E-12
+ VJE=0.735
+ MJE=0.384
+ FC=0.526
+ TR=0.129E-07
+ TF=0.849E-10
+ ITF=0.332
+ VTF=6.784
+ XTF=0.505
+)

.param fin = 1000
CA Vcc 0 100n
CB Vcc 0 100u
Q5 N002 N003 N004 0 BD139
R12 Vcc N002 220
Q4 N003 N001 Vcc 0 BD140
Q9 N003 N005 N006 0 BC546B
R16 N003 N005 1k
RPot2 N005 N006 1k
C4 N001 N003 100p
R6 Vcc N001 560
R13 N004 Out .33
R5 Out N010 22k
Q2 Vcc N010 N011 0 BC546B
Q1 N001 N009 N011 0 BC546B
R4 N010 N014 1k
R9 N006 N017 3.3k
R10 N017 Vee 3.3k
Q6 N016 N006 N012 0 BD140
C6 N006 N016 100p
R14 Out N012 .33
Q8 N012 N016 Vee 0 TIP35
R11 N016 Vee 220
R15 Out N013 10
C7 N013 0 100n
CD 0 Vee 100n
Q3 N011 N015 N018 0 BC546B
R7 N018 Vee 560
R8 N015 0 22k
R2 N008 0 22k
R3 N009 N008 1k
C10 N008 0 100p
R1 N008 N007 1k
C1 N007 In 4.7u
C3 0 N014 100u
C5 Out N017 100u
CE 0 Vee 100u
V1 Vcc 0 35
V2 0 Vee 35
V3 In 0 SINE(0 1 {fin})
R17 Out 0 8
Q7 N004 N002 Vcc 0 TIP36
V4 N015 Vee 2V

.control

*FOR TRANSIENT ANALYSIS USE THESE TWO:
tran 10u 1m
plot v(Out)

*FOR AC/FREQUENCY CHECK USE THESE TWO:
ac dec 100 1 100k
plot dB(v(Out))

*FOR Total Harmonic Distortion(THD):
*Make sure that V2 and V3 freq match the fourier frequency

alterparam fin = 20
reset
tran 100u 1.5 1.0
fourier 20 v(Out)

alterparam fin = 1k
reset
tran 10u 300m 250m
fourier 1k v(Out)

alterparam fin = 20k
reset
tran 10u 300m 250m
fourier 20k v(Out)
.endc
.end
